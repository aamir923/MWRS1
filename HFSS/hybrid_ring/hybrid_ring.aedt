# Ansys Electronics Desktop project, version 2024.2
materials:
  vacuum: permittivity=1
  FR4_epoxy: permittivity=4.4 dielectric_loss_tangent=0.02
  air: permittivity=1.0006 permeability=1.0000004

design HFSSDesign1 (HFSS, HFSS Terminal Network, model units mm)
options: Allow_Material_Override
geometry:
  ring = circle(normal=Z, centre=(0mm, 0mm, 0mm), radius=17.52mm)
  Circle2 = circle(normal=Z, centre=(0mm, 0mm, 0mm), radius=15.9mm)
  ring.subtract(Circle2)
  port = rectangle(corner=(-1.5mm, -30mm, 0mm), x_size=3mm, y_size=14mm)
  port_2 = port.duplicate_around_axis(axis=Z, angle=-90deg, total=2)
  port_4 = port.duplicate_around_axis(axis=Z, angle=90deg, total=2)
  port_1 = port.duplicate_around_axis(axis=Z, angle=-30deg, total=2)
  port_3 = port.duplicate_around_axis(axis=Z, angle=30deg, total=2)
  port.delete()
  ring.unite(port_1..port_4)
  ring.rotate(axis=Z, angle=30deg)
  ground [vacuum] = polyhedron(axis=Z, centre=(0mm, 0mm, 0mm), first_corner=(30/cos(30*pi/180) mm, 0mm, 0mm), sides=6, height=0mm)
  substrate [FR4_epoxy] = polyhedron(axis=Z, centre=(0mm, 0mm, 0mm), first_corner=(30/cos(30*pi/180) mm, 0mm, 0mm), sides=6, height=-1.6mm)
  ground.move(0mm, 7.1054274e-15mm, -1.6mm)
  [ring, ground, substrate].rotate(axis=Z, angle=30deg)
  Rectangle1 = rectangle(corner=(30mm, -1.5mm, 0mm), y_size=3mm, z_size=-1.6mm)
  [ring, ground, substrate, Rectangle1].rotate(axis=Z, angle=30deg)
  Rectangle2 = rectangle(corner=(-1.5mm, -30mm, 0mm), z_size=-1.6mm, x_size=3mm)
  Rectangle3 = rectangle(corner=(1.5mm, 30mm, 0mm), z_size=-1.6mm, x_size=-3mm)
  [ring, ground, substrate, Rectangle1, Rectangle2, Rectangle3].rotate(axis=Z, angle=30deg)
  Rectangle4 = rectangle(corner=(30mm, -1.5mm, 0mm), y_size=3mm, z_size=-1.6mm)
  ring.rotate(axis=Z, angle=60deg)
  ground.rotate(axis=Z, angle=60deg)
  substrate.rotate(axis=Z, angle=60deg)
  Rectangle1.rotate(axis=Z, angle=60deg)
  Rectangle2.rotate(axis=Z, angle=60deg)
  Rectangle3.rotate(axis=Z, angle=60deg)
  Rectangle4.rotate(axis=Z, angle=60deg)
  [ring, ground, substrate, Rectangle1..Rectangle4].rotate(axis=Z, angle=60deg)
  [ring, ground, substrate, Rectangle1..Rectangle4].rotate(axis=Z, angle=30deg)
  [ring, ground, substrate, Rectangle1..Rectangle4].rotate(axis=Z, angle=60deg)
  ring.rotate(axis=Z, angle=30deg)
  ground.rotate(axis=Z, angle=30deg)
  substrate.rotate(axis=Z, angle=30deg)
  Rectangle1.rotate(axis=Z, angle=30deg)
  Rectangle2.rotate(axis=Z, angle=30deg)
  Rectangle3.rotate(axis=Z, angle=30deg)
  Rectangle4.rotate(axis=Z, angle=30deg)
  [ring, ground, substrate, Rectangle1..Rectangle4].rotate(axis=Z, angle=30deg)
  [ring, ground, substrate, Rectangle1..Rectangle4].rotate(axis=Z, angle=-90deg)
  [ring, ground, substrate, Rectangle1..Rectangle4].rotate(axis=Z, angle=-30deg)
  Box1 [air] = box(corner=(-50mm, -50mm, -50mm), size=(100mm, 100mm, 100mm))
boundaries and excitations:
  PerfE1: Perfect E Objects=ring
  PerfE2: Perfect E Objects=ground
  Rad1: Radiation Objects=Box1
  4: Lumped Port Objects=Rectangle3 LumpedPortType=Modal Modes{Mode1{IntLine{(0, -30, -1.6) -> (0, -30, 0)} CharImp=Zpi}} Impedance=50ohm
  2: Lumped Port Objects=Rectangle2 LumpedPortType=Modal Modes{Mode1{IntLine{(0, 30, -1.6) -> (0, 30, 0)} CharImp=Zpi}} Impedance=50ohm
  3: Lumped Port Objects=Rectangle1 LumpedPortType=Modal Modes{Mode1{IntLine{(-25.980762, -15, -1.6) -> (-25.980762, -15, 0)} CharImp=Zpi}} Impedance=50ohm
  1: Lumped Port Objects=Rectangle4 LumpedPortType=Modal Modes{Mode1{IntLine{(-25.980762, 15, -1.6) -> (-25.980762, 15, 0)} CharImp=Zpi}} Impedance=50ohm
setups:
  Setup1: HfssDriven Frequency=2.4GHz MaxDeltaS=0.02 MaximumPasses=6 MinimumPasses=1 MinimumConvergedPasses=1 PercentRefinement=30 BasisOrder=1 PortAccuracy=2 DrivenSolverType="Direct Solver"
    sweep Sweep: 1GHz to 5GHz, 100 points; Type=Interpolating InterpTolerance=0.5 InterpMaxSolns=250 PassivityErrorTolerance=0.0001
source amplitudes:
  4:1, 2:1, 3:1: 1W 0deg
  1:1: 0W 0deg
field plots:
  Mag_E1: E Field over Rectangle2.face(at (0, 30, -0.8)) ring.face(at (-4.60538, 0, 0)) on Setup1 : LastAdaptive at Freq=2.4GHz Phase=0deg
reports:
  S Parameter Plot 1: dB(S(1,1)), dB(S(2,1)), dB(S(1,2)), dB(S(2,2)) vs Freq on Setup1 : Sweep
